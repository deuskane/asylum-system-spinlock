{
    name      : "spinlock",
    width     : 8,
    desc      : "CSR for spinlock"
    interface : "sbi"

    registers : [

        {
            name         : "lock0",
            address      : "x0",
            desc         : "Lock 0",
            swaccess     : "rsw0c",
            hwaccess     : "none",
            hwtype       : "reg",

            fields: [
                {
                    name: "value",
                    bits: "7:0",
		    init: "x00",
                    desc: "0: lock free, 1: lock acquiered"
                },
            ]
        },

        {
            name         : "lock1",
            address      : "x1",
            desc         : "Lock 1",
            swaccess     : "rsw0c",
            hwaccess     : "none",
            hwtype       : "reg",

            fields: [
                {
                    name: "value",
                    bits: "7:0",
		    init: "x00",
                    desc: "0: lock free, 1: lock acquiered"
                },
            ]
        },

]
}
