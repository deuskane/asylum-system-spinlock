{
    name      : "spinlock",
    width     : 8,
    desc      : "CSR for spinlock"
    interface : "sbi"

    registers : [

        {
            name         : "lock0",
            address      : "x0",
            desc         : "Lock 0 (test-and-set on read, write 0x00 to release)",
            swaccess     : "rsw0c",
            hwaccess     : "none",
            hwtype       : "reg",

            fields: [
                {
                    name: "value",
                    bits: "7:0",
                    init: "x00",
                    desc: "Read: returns the lock state then takes the lock (all bits set to 1) - 0x00: lock was free and is now owned by the reader, 0xFF (any non-zero value): lock already taken. Write: bits written to 0 are cleared (write 0x00 to release), a write never takes the lock"
                },
            ]
        },

        {
            name         : "lock1",
            address      : "x1",
            desc         : "Lock 1 (test-and-set on read, write 0x00 to release)",
            swaccess     : "rsw0c",
            hwaccess     : "none",
            hwtype       : "reg",

            fields: [
                {
                    name: "value",
                    bits: "7:0",
	                init: "x00",
                    desc: "Read: returns the lock state then takes the lock (all bits set to 1) - 0x00: lock was free and is now owned by the reader, 0xFF (any non-zero value): lock already taken. Write: bits written to 0 are cleared (write 0x00 to release), a write never takes the lock"
                },
            ]
        },

]
}
